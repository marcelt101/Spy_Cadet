A1 bootstrapped input / gain stage
.include models.lib
.include hvoa.sub
.param rf=47k
VP VP 0 40
VN VN 0 -40
* source: passive pickup approx 8k + 3H (worst case) is for noise; here ideal
VIN SRC 0 DC 0 AC 1 SIN(0 1 1k)
RS SRC JACK 1
RST JACK IN1 1k
CRF IN1 0 100p
CIN IN1 INP 2.2u
RA INP BS 100k
RB BS 0 100k
CB INN BS 2.2u
X1 INP INN OUT VP VN 0 HVOA
RF OUT INN {rf+470}
CF OUT INN 22p
RG INN G 2.2k
CG G 0 220u
RL OUT 0 10k
CL OUT 0 220p
.control
foreach r 0 47k
  alterparam rf=$r
  reset
  op
  print v(out)
  ac dec 40 0.1 1Meg
  let g = db(v(out))
  meas ac g1k find g at=1k
  meas ac gmax max g
  meas ac g2 find g at=2
  meas ac g5 find g at=5
  meas ac g10 find g at=10
  meas ac g20k find g at=20k
  meas ac g100k find g at=100k
  meas ac f3hi when g=g1k-3 fall=1
  let zin = mag(v(jack)/i(vin))*-1
  let zin = abs(v(jack)/(-i(vin)))
  meas ac zin20 find zin at=20
  meas ac zin1k find zin at=1k
  meas ac zin10k find zin at=10k
end
.endc
.end
