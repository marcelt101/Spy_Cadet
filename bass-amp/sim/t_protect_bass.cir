Speaker relay / mute / protection logic (poweramp board), timing check
.include models.lib
.model 1N4007 D(IS=7n RS=0.04 N=1.8 BV=1000 IBV=5u)
.model DZ12 D(IS=1n RS=10 N=1.5 BV=12 IBV=1m)
.model BD139 NPN(IS=1e-13 BF=80 VAF=100 IKF=1 RB=5 RC=0.2 CJC=30p CJE=80p TF=5n)
.param tac=8 tdc=12 dcv=0
VCC VCC 0 PWL(0 0 0.2 28)
VEE VEE 0 PWL(0 0 0.2 -28)
* AC sense: 28 Vpk 50 Hz, disappears at t=tac
VAC AC_IN 0 SIN(0 28 50)
SAC AC_IN ACX ACON 0 SW1
VACON ACON 0 PWL(0 1 {tac} 1 {tac+1m} 0)
.model SW1 SW(VT=0.5 RON=1 ROFF=1G)
* amplifier outputs: DC fault on A_OUT appears at t=tdc
VA A_OUT 0 SIN(0 25 30)
VB B_OUT 0 0
* relay coil 24 V, 1.44k
RCOIL COILP COILN 1.44k
R40 VCC T 100k
C40 T 0 47u
D40 TZ T DZ12
R41 TZ DB 10k
R42 DB 0 47k
Q32 COILN DB Q33B MPSA42
Q33 COILN Q33B 0 BD139
R43 Q33B 0 10k
R44 VCC COILP 220
D41 COILN COILP 1N4007
R49 T TD 100
D42 ACX AC1 D1N4148
R45 AC1 ACA 22k
C41 ACA 0 1u
R46 ACA 0 47k
R47 ACA Q36B 100k
Q36 Q35B Q36B 0 2N5210
R48 VCC Q35B 47k
Q35 TD Q35B 0 2N5210
R51 A_OUT DCA 47k
C50 DCA 0 47u
R52 DCA Q37R 10k
D50 Q37R Q37B D1N4148
R55 Q37B 0 47k
Q37 TD Q37B 0 2N5210
R53 DCA DCA2 1k
D51 Q38E DCA2 D1N4148
R54 Q38B 0 10k
Q38 TD Q38B Q38E 2N5210
R71 COILN Q41B 100k
R72 Q41B VCC 100k
Q41 Q41C Q41B VCC MPSA92
R73 Q41C Q30B 47k
R74 Q30B VEE 47k
* LM3886 mute pins modelled as -2.6 V sources through 20k each
VM8 M8 0 -2.6
R7 M8 MUTE_N 20k
R17 M8 MUTE_N 20k
Q30 MUTE_N Q30B VEE MPSA42
.control
tran 1m 8 0 1m uic
let vr=v(coilp)-v(coiln)
meas tran vmin min vr from=5 to=8
meas tran vdca max v(dca) from=5 to=8
.endc
.end
