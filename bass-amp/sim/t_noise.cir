A1 noise with passive pickup source (8k + 3 H + 300p cable)
.include models.lib
.include hvoa.sub
VP VP 0 40
VN VN 0 -40
VIN S 0 DC 0 AC 1
RPU S S1 8k
LPU S1 JACK 3
CCAB JACK 0 300p
RST JACK IN1 1k
CRF IN1 0 100p
CIN IN1 INP 2.2u
RA INP BS 2.2Meg
RB BS 0 100k
CB INN BS 2.2u
X1 INP INN OUT VP VN 0 HVOA
RF OUT INN 10k
CF OUT INN 22p
RG INN G 2.2k
CG G 0 220u
RL OUT 0 10k
* same source with a noiseless 'reference' copy is not possible; compare against pickup-only
.nodeset v(x1.tail)=1 v(out)=0 v(inp)=0 v(inn)=0
.control
noise v(out) VIN dec 20 20 20k
setplot noise2
print inoise_total onoise_total
setplot noise1
let pu = 4*1.38e-23*300*8000
* integrate only the pickup resistor contribution is not exposed simply; report spot noise
let inz = inoise_spectrum
meas noise in100 find inz at=100
meas noise in1k find inz at=1k
meas noise in5k find inz at=5k
print sqrt(pu)
.endc
.end
