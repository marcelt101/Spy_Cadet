Final A1 (input) and A2 (FX return) checks
.include models.lib
.include hvoa.sub
.param amp=1 f=1k rf=47k
VP VP 0 PWL(0 0 50m 40)
VN VN 0 PWL(0 0 70m -40)
* ---- A1: bootstrapped input / gain stage ----
VIN JACK 0 DC 0 SIN(0 0.1 1k)
RST JACK IN1 1k
CRF IN1 0 100p
CIN IN1 INP 2.2u
RA INP BS 1Meg
RB BS 0 100k
CB INN BS 2.2u
X1 INP INN OUT VP VN 0 HVOA params: rtail=3k rsink=10k re=1k cc=68p
RF OUT INN {rf+470}
CF OUT INN 22p
RG INN G 2.2k
CG G 0 220u
RL OUT 0 10k
CL OUT 0 220p
* ---- A2: unity FX-return buffer, same input network ----
VIN2 RJ 0 DC 0 SIN(0 0.1 1k)
RST2 RJ IN2 1k
CRF2 IN2 0 100p
CIN2 IN2 INP2 2.2u
RA2 INP2 BS2 1Meg
RB2 BS2 0 100k
CB2 OUT2 BS2 2.2u
X2 INP2 INN2 OUT2 VP VN 0 HVOA params: rtail=820 rsink=3.3k re=470 cc=150p
RF2 OUT2 INN2 1k
RL2 OUT2 0 10k
CL2 OUT2 0 220p
.control
tran 20u 400m 0 50u uic
meas tran o1 avg v(out) from=380m to=400m
meas tran o2 avg v(out2) from=380m to=400m
meas tran a1 pp v(out) from=380m to=400m
meas tran a2 pp v(out2) from=380m to=400m
.endc
.end
