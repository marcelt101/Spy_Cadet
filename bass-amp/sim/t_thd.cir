A1 THD
.include models.lib
.include hvoa.sub
.param rf=47k amp=1 f=1k
VP VP 0 40
VN VN 0 -40
VIN JACK 0 DC 0 SIN(0 {amp} {f})
RST JACK IN1 1k
CRF IN1 0 100p
CIN IN1 INP 2.2u
RA INP BS 100k
RB BS 0 100k
CB INN BS 2.2u
X1 INP INN OUT VP VN 0 HVOA
RF OUT INN {rf+470}
CF OUT INN 22p
RG INN G 2.2k
CG G 0 220u
RL OUT 0 10k
.options reltol=1e-5 abstol=1e-13 vntol=1e-8
.control
* min gain (x1.22): 20 Vrms out at 1 kHz
alterparam rf=0
alterparam amp=23.2
reset
tran 2u 12m 0 2u
fourier 1k v(out)
* max gain (x22.6): 1.25 Vrms in -> 28 Vrms out (+31 dBu) at 1 kHz
alterparam rf=47k
alterparam amp=1.75
reset
tran 2u 12m 0 2u
fourier 1k v(out)
* max gain, 1 Vrms -> 22.6 Vrms at 10 kHz
alterparam amp=1.41
alterparam f=10k
reset
tran 0.2u 1.2m 0 0.2u
fourier 10k v(out)
.endc
.end
