Reference: noiseless amp with a conventional 1M input resistor
VIN S 0 DC 0 AC 1
RPU S S1 8k
LPU S1 JACK 3
CCAB JACK 0 300p
CRF JACK 0 100p
RIN JACK 0 1Meg
E1 OUT 0 JACK 0 5.545
.control
noise v(out) VIN dec 20 20 20k
.endc
.end
