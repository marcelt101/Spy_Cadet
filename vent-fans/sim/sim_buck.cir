* PROPOSED: low-side buck. One inductor added; caps on rail and across fans.
.include models.inc
.param duty=0.6 per=25u lval=100u
.include harness_buck.inc
.control
.include measure_buck.inc
.endc
.end
